* CDL from outputs/controller_lvs.v
.INCLUDE '/home/user22/Sky130_cadence_pdk/sky130_scl_9T_0.1.1/sky130_scl_9T/cdl/sky130_scl_9T.cdl'
.SUBCKT controller CLK_IN CLK1 CLK2 CLK3 EN RSTN COMP_IN CLK_OUT SA_EN CLK_EN VCM_CON VCM_CON_N PA_EN PA_EN_N SAMPLE_P SAMPLE_N VREF_SEL_1_P[1] VREF_SEL_1_P[0] VREF_SEL_2_P VREF_SEL_4_P[6] VREF_SEL_4_P[5] VREF_SEL_4_P[4] VREF_SEL_4_P[3] VREF_SEL_4_P[2] VREF_SEL_4_P[1] VREF_SEL_4_P[0] VREF_SEL_8_P[27] VREF_SEL_8_P[26] VREF_SEL_8_P[25] VREF_SEL_8_P[24] VREF_SEL_8_P[23] VREF_SEL_8_P[22] VREF_SEL_8_P[21] VREF_SEL_8_P[20] VREF_SEL_8_P[19] VREF_SEL_8_P[18] VREF_SEL_8_P[17] VREF_SEL_8_P[16] VREF_SEL_8_P[15] VREF_SEL_8_P[14] VREF_SEL_8_P[13] VREF_SEL_8_P[12] VREF_SEL_8_P[11] VREF_SEL_8_P[10] VREF_SEL_8_P[9] VREF_SEL_8_P[8] VREF_SEL_8_P[7] VREF_SEL_8_P[6] VREF_SEL_8_P[5] VREF_SEL_8_P[4] VREF_SEL_8_P[3] VREF_SEL_8_P[2] VREF_SEL_8_P[1] VREF_SEL_8_P[0] VREF_SEL_1_N[1] VREF_SEL_1_N[0] VREF_SEL_2_N VREF_SEL_4_N[6] VREF_SEL_4_N[5] VREF_SEL_4_N[4] VREF_SEL_4_N[3] VREF_SEL_4_N[2] VREF_SEL_4_N[1] VREF_SEL_4_N[0] VREF_SEL_8_N[27] VREF_SEL_8_N[26] VREF_SEL_8_N[25] VREF_SEL_8_N[24] VREF_SEL_8_N[23] VREF_SEL_8_N[22] VREF_SEL_8_N[21] VREF_SEL_8_N[20] VREF_SEL_8_N[19] VREF_SEL_8_N[18] VREF_SEL_8_N[17] VREF_SEL_8_N[16] VREF_SEL_8_N[15] VREF_SEL_8_N[14] VREF_SEL_8_N[13] VREF_SEL_8_N[12] VREF_SEL_8_N[11] VREF_SEL_8_N[10] VREF_SEL_8_N[9] VREF_SEL_8_N[8] VREF_SEL_8_N[7] VREF_SEL_8_N[6] VREF_SEL_8_N[5] VREF_SEL_8_N[4] VREF_SEL_8_N[3] VREF_SEL_8_N[2] VREF_SEL_8_N[1] VREF_SEL_8_N[0] uo_out[7] uo_out[6] uo_out[5] uo_out[4] uo_out[3] uo_out[2] uo_out[1] uo_out[0] uio_out[7] uio_out[6] uio_out[5] uio_out[4] uio_out[3] uio_out[2] uio_out[1] uio_out[0] uio_oe[7] uio_oe[6] uio_oe[5] uio_oe[4] uio_oe[3] uio_oe[2] uio_oe[1] uio_oe[0]
XFE_OFC12_n_29 n_29 FE_OFN12_n_29 VDD VSS BUFX2
XFE_OFC11_n_96 n_96 FE_OFN11_n_96 VDD VSS BUFX2
XFE_OFC10_n_65 n_65 FE_OFN10_n_65 VDD VSS BUFX2
XFE_OFC9_VREF_SEL_2_P VREF_SEL_2_P FE_OFN9_VREF_SEL_2_P VDD VSS BUFX2
XFE_OFC8_VREF_SEL_1_N_0 FE_OFN8_VREF_SEL_1_N_0 VREF_SEL_1_N[0] VDD VSS BUFX2
XFE_OFC7_VREF_SEL_8_N_20 FE_RN_1 VREF_SEL_8_N[20] VDD VSS BUFX2
XFE_OFC6_VREF_SEL_4_N_4 FE_OFN6_VREF_SEL_4_N_4 VREF_SEL_4_N[4] VDD VSS BUFX2
XFE_OFC5_state_1 state[1] FE_OFN5_state_1 VDD VSS BUFX2
XFE_OFC4_n_2 n_2 FE_OFN4_n_2 VDD VSS BUFX2
XFE_OFC3_VREF_SEL_4_P_4 FE_OFN3_VREF_SEL_4_P_4 VREF_SEL_4_P[4] VDD VSS BUFX2
XFE_OFC2_VREF_SEL_1_P_0 FE_OFN2_VREF_SEL_1_P_0 VREF_SEL_1_P[0] VDD VSS BUFX2
XFE_OFC1_VREF_SEL_8_P_0 FE_OFN1_VREF_SEL_8_P_0 VREF_SEL_8_P[27] VDD VSS BUFX16
XFE_OFC0_VREF_SEL_8_N_0 FE_OFN0_VREF_SEL_8_N_0 VREF_SEL_8_N[27] VDD VSS BUFX16
XCTS_ccl_a_inv_00010 CTS_8 SA_EN VDD VSS INVX4
XCTS_ccl_a_inv_00013 CTS_9 CTS_8 VDD VSS CLKINVX1
XCTS_ccl_a_inv_00016 CTS_6 PA_EN VDD VSS INVX4
XCTS_ccl_a_inv_00020 CTS_7 CTS_6 VDD VSS CLKINVX1
XCTS_ccl_a_inv_00035 CTS_10 CTS_11 VDD VSS CLKINVX1
XCTS_ccl_a_inv_00003 CTS_4 VCM_CON VDD VSS INVX4
XCTS_ccl_a_inv_00007 CTS_5 CTS_4 VDD VSS INVX2
XCTS_ccl_a_inv_00038 CTS_12 CTS_10 VDD VSS CLKINVX1
XCTS_ccl_a_inv_00042 CLK1 CTS_12 VDD VSS INVX2
XCTS_ccl_a_inv_00027 CTS_3 CTS_1 VDD VSS CLKINVX8
XCTS_ccl_a_inv_00025 CTS_3 CTS_2 VDD VSS CLKINVX8
XCTS_ccl_a_inv_00030 CLK1 CTS_3 VDD VSS CLKINVX8
Xtie_hi_0 uio_oe[0] VDD VSS TIEHI
Xtie_lo_1 uio_oe[1] VDD VSS TIELO
Xtie_lo_2 uio_oe[2] VDD VSS TIELO
Xtie_lo_3 uio_oe[3] VDD VSS TIELO
Xtie_lo_4 uio_oe[4] VDD VSS TIELO
Xtie_lo_5 uio_oe[5] VDD VSS TIELO
Xtie_lo_6 uio_oe[6] VDD VSS TIELO
Xtie_lo_7 uio_oe[7] VDD VSS TIELO
Xtie_lo_8 uio_out[1] VDD VSS TIELO
Xtie_lo_9 uio_out[2] VDD VSS TIELO
Xtie_lo_10 uio_out[3] VDD VSS TIELO
Xtie_lo_11 uio_out[4] VDD VSS TIELO
Xtie_lo_12 uio_out[5] VDD VSS TIELO
Xtie_lo_13 uio_out[6] VDD VSS TIELO
Xtie_lo_14 uio_out[7] VDD VSS TIELO
Xtie_hi_15 VREF_SEL_1_P[1] VDD VSS TIEHI
Xclk_out_buf CLK_IN CLK_OUT VDD VSS CLKBUFX8
Xg2660 VCM_CON VCM_CON_N VDD VSS INVX4
Xg2661 PA_EN PA_EN_N VDD VSS INVX4
Xg2670 b_reg[6] uo_out[6] VDD VSS INVX2
Xg2672 b_reg[3] uo_out[3] VDD VSS INVX2
Xg2673 b_reg[4] uo_out[4] VDD VSS INVX2
Xg2662 b_reg[7] uo_out[7] VDD VSS INVX2
Xg2664 b_reg[2] uo_out[2] VDD VSS INVX2
Xg2671 b_reg[0] uo_out[0] VDD VSS INVX2
Xg2665 b_reg[5] uo_out[5] VDD VSS INVX2
Xg2663 b_reg[1] uo_out[1] VDD VSS INVX2
Xg2728__8780 n_124 n_139 n_133 VDD VSS NAND2X1
Xg2729__4296 state[3] n_123 n_139 VDD VSS NAND2X1
Xg2730__3772 state[2] n_142 n_16 n_124 VDD VSS OAI21X1
Xg2731__1474 state[2] n_16 n_137 VDD VSS NAND2X2
Xg2732 n_123 n_140 VDD VSS INVX1
Xg2733__4547 n_142 n_141 n_123 VDD VSS NOR2X1
Xg2734 n_16 n_138 VDD VSS CLKINVX2
Xg2735__9682 n_6 EN n_141 VDD VSS NAND2X1
Xg2736__2683 state[3] n_14 n_16 VDD VSS NOR2X2
Xg2737__1309 RSTN SAMPLE_P n_135 VDD VSS NAND2X1
Xg2738__6877 FE_OFN5_state_1 state[0] n_142 VDD VSS OR2X1
Xg2758__2900 n_135 n_119 CTS_5 VDD VSS NOR2X2
Xg2759__2391 CTS_10 n_118 EN n_119 VDD VSS OAI21X1
Xg2760__7675 CLK3 CLK2 n_133 CTS_11 CTS_9 VDD VSS AND4X1
Xg2761__7118 CLK2 CTS_11 n_133 CTS_7 VDD VSS AND3X1
Xg2762__8757 CLK3 CLK2 n_118 VDD VSS NOR2X1
X\cn_reg_reg[2] CTS_1 n_114 FE_OFN6_VREF_SEL_4_N_4 UNCONNECTED RSTN VDD VSS DFFSX1
X\cp_reg_reg[4] CTS_1 n_110 VREF_SEL_4_P[6] n_4 RSTN VDD VSS DFFSX4
X\cp_reg_reg[0] CTS_1 n_113 FE_OFN2_VREF_SEL_1_P_0 UNCONNECTED0 RSTN VDD VSS DFFSX1
Xg3882__1786 n_47 n_71 n_94 n_41 n_114 VDD VSS NAND4X1
X\cn_reg_reg[3] CTS_1 n_112 VREF_SEL_4_N[5] UNCONNECTED1 RSTN VDD VSS DFFSX4
X\cn_reg_reg[1] CTS_1 n_111 VREF_SEL_2_N UNCONNECTED2 RSTN VDD VSS DFFSX1
X\cp_reg_reg[2] CTS_1 n_109 FE_OFN3_VREF_SEL_4_P_4 UNCONNECTED3 RSTN VDD VSS DFFSX1
X\cn_reg_reg[7] CTS_2 n_108 FE_OFN0_VREF_SEL_8_N_0 n_9 RSTN VDD VSS DFFSX1
X\cp_reg_reg[5] CTS_2 n_101 VREF_SEL_8_P[21] UNCONNECTED4 RSTN VDD VSS DFFSX4
X\cp_reg_reg[6] CTS_2 n_100 n_116 n_1 RSTN VDD VSS DFFSX1
X\cp_reg_reg[1] CTS_2 n_103 VREF_SEL_2_P UNCONNECTED5 RSTN VDD VSS DFFSX1
X\cn_reg_reg[6] CTS_1 n_106 n_115 n_0 RSTN VDD VSS DFFSX1
Xg3891__5953 COMP_IN n_140 n_98 n_93 n_113 VDD VSS OAI211X1
Xg3892__5703 n_71 n_102 n_112 VDD VSS NAND2X1
Xg3893__7114 n_71 n_105 n_111 VDD VSS NAND2X1
Xg3894__5266 n_88 n_4 COMP_IN n_23 n_98 n_110 VDD VSS OAI221X1
X\cn_reg_reg[5] CTS_1 n_107 FE_RN_2 UNCONNECTED6 RSTN VDD VSS DFFSX4
X\cp_reg_reg[3] CTS_2 n_99 VREF_SEL_4_P[5] UNCONNECTED7 RSTN VDD VSS DFFSX4
X\b_reg_reg[5] CTS_2 b_reg[5] b_reg[5] UNCONNECTED8 n_62 dat[5] RSTN VDD VSS SDFFSX1
X\cp_reg_reg[7] CTS_2 n_90 FE_OFN1_VREF_SEL_8_P_0 n_11 RSTN VDD VSS DFFSX1
X\b_reg_reg[2] CTS_2 b_reg[2] b_reg[2] UNCONNECTED9 n_62 dat[2] RSTN VDD VSS SDFFSX1
X\b_reg_reg[4] CTS_2 b_reg[4] b_reg[4] UNCONNECTED10 n_62 dat[4] RSTN VDD VSS SDFFSX1
X\b_reg_reg[0] CTS_2 b_reg[0] b_reg[0] UNCONNECTED11 n_62 dat[0] RSTN VDD VSS SDFFSX1
X\b_reg_reg[1] CTS_2 b_reg[1] b_reg[1] UNCONNECTED12 n_62 dat[1] RSTN VDD VSS SDFFSX1
X\b_reg_reg[6] CTS_2 b_reg[6] b_reg[6] UNCONNECTED13 n_62 dat[6] RSTN VDD VSS SDFFSX1
X\b_reg_reg[3] CTS_2 b_reg[3] b_reg[3] UNCONNECTED14 n_62 dat[3] RSTN VDD VSS SDFFSX1
X\b_reg_reg[7] CTS_2 b_reg[7] b_reg[7] UNCONNECTED15 n_62 dat[7] RSTN VDD VSS SDFFSX1
X\state_reg[3] CTS_1 n_95 state[3] n_7 RSTN VDD VSS DFFRX1
X\state_reg[2] CTS_1 n_91 state[2] n_6 RSTN VDD VSS DFFRX1
Xg3908 n_104 n_109 VDD VSS INVX1
Xg3909__2250 FE_OFN5_state_1 n_43 n_9 n_53 n_98 n_108 VDD VSS OAI221X1
Xg3910__6083 n_71 FE_OFN11_n_96 n_107 VDD VSS NAND2X1
Xg3911__2703 n_39 n_71 n_76 n_106 VDD VSS NAND3X1
Xg3912__5795 n_55 VREF_SEL_2_N FE_OFN5_state_1 FE_OFN12_n_29 n_46 n_105 VDD VSS AOI221X1
Xg3913__7344 VREF_SEL_4_P[4] n_37 n_12 n_46 n_97 n_104 VDD VSS AOI221X1
Xg3914__1840 COMP_IN n_45 n_38 n_98 n_103 VDD VSS OAI211X1
Xg3915__5019 n_58 VREF_SEL_4_N[5] FE_OFN4_n_2 FE_OFN12_n_29 n_32 n_102 VDD VSS AOI221X1
Xg3916__1857 COMP_IN n_48 n_70 n_98 n_101 VDD VSS OAI211X1
Xg3917__9906 COMP_IN n_52 n_69 n_98 n_100 VDD VSS OAI211X1
Xg3918__8780 COMP_IN n_47 n_34 n_98 n_99 VDD VSS OAI211X1
Xeoc_reg_reg CTS_2 n_92 uio_out[0] n_5 RSTN VDD VSS DFFRX1
Xcnc_reg_reg CTS_1 n_86 SAMPLE_P UNCONNECTED16 RSTN VDD VSS DFFSX4
X\cn_reg_reg[4] CTS_1 n_84 VREF_SEL_4_N[6] UNCONNECTED17 RSTN VDD VSS DFFSX4
X\dat_reg[6] CTS_2 n_89 dat[6] UNCONNECTED18 RSTN VDD VSS DFFRX1
X\dat_reg[7] CTS_2 n_77 dat[7] UNCONNECTED19 RSTN VDD VSS DFFRX1
X\dat_reg[5] CTS_2 n_80 dat[5] UNCONNECTED20 RSTN VDD VSS DFFRX1
X\dat_reg[3] CTS_2 n_82 dat[3] UNCONNECTED21 RSTN VDD VSS DFFRX1
X\dat_reg[2] CTS_1 n_79 dat[2] n_10 RSTN VDD VSS DFFRX1
X\dat_reg[1] CTS_2 n_83 dat[1] UNCONNECTED22 RSTN VDD VSS DFFRX1
X\state_reg[1] CTS_1 n_81 state[1] n_2 RSTN VDD VSS DFFRX1
Xg3929 n_97 n_98 VDD VSS CLKINVX2
Xg3930__4296 n_31 n_25 FE_RN_2 n_36 FE_OFN5_state_1 n_44 n_96 VDD VSS AOI222X1
Xg3931__3772 n_78 n_45 n_95 VDD VSS NAND2X1
Xg3932__1474 state[0] n_54 VREF_SEL_4_N[4] n_94 VDD VSS OAI21X1
Xg3933__4547 n_63 n_56 VREF_SEL_1_P[0] n_93 VDD VSS OAI21X1
Xg3934__9682 FE_OFN10_n_65 n_5 n_61 n_92 VDD VSS OAI21X1
Xg3935__2683 n_6 n_64 n_42 n_91 VDD VSS OAI21X1
Xg3936__1309 COMP_IN n_39 n_11 n_53 n_71 n_90 VDD VSS OAI221X1
X\cn_reg_reg[0] CTS_1 n_85 FE_OFN8_VREF_SEL_1_N_0 UNCONNECTED23 RSTN VDD VSS DFFSX1
Xg3938__6877 n_23 n_60 state[2] n_97 VDD VSS AOI21X1
Xg3939 n_87 n_89 VDD VSS CLKINVX1
Xg3940__2900 state[2] n_142 n_138 n_49 n_88 VDD VSS AOI211X1
Xg3941__2391 dat[6] n_33 n_72 n_87 VDD VSS AOI21X1
Xg3942__7675 n_71 n_66 n_86 VDD VSS NAND2X1
Xg3943__7118 n_71 n_45 n_35 n_85 VDD VSS NAND3X1
Xg3944__8757 n_48 n_57 n_84 VDD VSS NAND2X1
X\dat_reg[4] CTS_1 n_59 dat[4] n_3 RSTN VDD VSS DFFRX1
X\state_reg[0] CTS_1 n_24 state[0] UNCONNECTED24 RSTN state[0] n_14 VDD VSS SDFFRX1
Xg3947 n_75 n_83 VDD VSS INVX1
Xg3948 n_74 n_82 VDD VSS INVX1
Xg3949 n_73 n_81 VDD VSS INVX1
Xg3950__1786 n_22 n_43 n_68 n_80 VDD VSS OAI21X1
Xg3951__5953 n_10 n_46 n_41 n_79 VDD VSS OAI21X1
Xg3952__5703 n_14 n_49 state[3] n_78 VDD VSS OAI21X1
Xg3953__7114 n_28 n_43 n_67 n_77 VDD VSS OAI21X1
Xg3954__5266 n_115 n_52 n_72 n_76 VDD VSS AOI21X1
Xg3955__2250 n_21 FE_OFN12_n_29 dat[1] n_45 n_75 VDD VSS AOI22X1
Xg3956__6083 n_27 FE_OFN12_n_29 dat[3] n_47 n_74 VDD VSS AOI22X1
Xg3957__2703 FE_OFN5_state_1 n_14 n_27 n_24 n_31 n_19 n_73 VDD VSS AOI222X1
Xg3958__5795 FE_OFN4_n_2 n_26 VREF_SEL_8_P[21] n_70 VDD VSS OAI21X1
Xg3959__7344 n_21 n_26 n_116 n_69 VDD VSS OAI21X1
Xg3960__1840 dat[5] n_42 n_68 VDD VSS NAND2X1
Xg3961__5019 dat[7] n_39 n_67 VDD VSS NAND2X1
Xg3962__1857 n_142 n_26 SAMPLE_P n_66 VDD VSS OAI21X1
Xg3963__9906 n_7 n_142 FE_OFN4_n_2 state[3] n_141 n_65 VDD VSS AOI221X1
Xg3964__8780 n_44 n_31 n_72 VDD VSS AND2X1
X\dat_reg[0] CTS_2 COMP_IN dat[0] UNCONNECTED25 RSTN n_139 dat[0] VDD VSS SDFFRX1
Xg3966__4296 n_7 n_48 n_71 VDD VSS OR2X2
Xg3967 n_63 n_64 VDD VSS INVX1
Xg3968 n_62 n_61 VDD VSS INVX1
Xg3969__3772 EN state[3] n_21 n_60 VDD VSS NAND3X1
Xg3970__1474 n_3 n_32 n_50 n_59 VDD VSS OAI21X1
Xg3971__4547 n_8 state[2] FE_OFN4_n_2 n_16 n_58 VDD VSS OAI211X1
Xg3972__9682 n_23 VREF_SEL_4_N[6] n_51 n_57 VDD VSS AOI21X1
Xg3973__2683 n_7 n_20 state[2] state[3] n_56 VDD VSS OAI22X1
Xg3974__1309 state[2] n_13 n_40 n_55 VDD VSS OAI21X1
Xg3975__6877 state[2] FE_OFN4_n_2 n_40 n_54 VDD VSS OAI21X1
Xg3976__2900 state[3] n_21 EN n_63 VDD VSS OAI21X1
Xg3977__2391 state[3] n_31 n_17 n_62 VDD VSS AND3X2
Xg3978 n_50 n_51 VDD VSS INVX1
Xg3979 n_44 n_43 VDD VSS CLKINVX2
Xg3980__7675 FE_OFN5_state_1 n_26 n_53 VDD VSS NOR2X1
Xg3981__7118 n_8 n_25 n_52 VDD VSS NAND2X1
Xg3982__8757 n_13 FE_OFN12_n_29 n_50 VDD VSS NAND2X1
Xg3983__1786 state[2] n_21 n_49 VDD VSS NOR2X1
Xg3984__5953 n_21 n_17 n_48 VDD VSS NAND2X1
Xg3985__5703 n_28 n_137 n_47 VDD VSS OR2X1
Xg3986__7114 n_30 n_137 n_46 VDD VSS NOR2X2
Xg3987__5266 n_22 n_137 n_45 VDD VSS OR2X1
Xg3988__2250 n_12 n_26 n_44 VDD VSS NOR2X1
Xg3989__6083 FE_OFN4_n_2 n_137 FE_OFN9_VREF_SEL_2_P n_38 VDD VSS OAI21X1
Xg3990__2703 n_21 n_13 n_137 n_37 VDD VSS OR3X1
Xg3991__5795 n_28 n_25 n_36 VDD VSS NAND2X1
Xg3992__7344 COMP_IN n_18 n_140 VREF_SEL_1_N[0] n_35 VDD VSS AOI22X1
Xg3993__1840 FE_OFN5_state_1 n_137 VREF_SEL_4_P[5] n_34 VDD VSS OAI21X1
Xg3994__5019 n_31 n_25 n_33 VDD VSS NAND2X1
Xg3995__1857 n_21 n_25 n_42 VDD VSS NAND2X1
Xg3996__9906 n_31 FE_OFN12_n_29 n_41 VDD VSS NAND2X1
Xg3997__8780 state[2] FE_OFN4_n_2 n_138 n_40 VDD VSS AOI21X1
Xg3998__4296 n_27 n_25 n_39 VDD VSS NAND2X1
Xg3999 n_30 n_31 VDD VSS CLKINVX2
Xg4000 n_28 n_27 VDD VSS CLKINVX2
Xg4001 n_26 n_25 VDD VSS CLKINVX2
Xg4002__3772 n_142 n_137 n_32 VDD VSS NOR2X1
Xg4003__1474 FE_OFN5_state_1 n_8 n_30 VDD VSS NAND2X1
Xg4004__4547 n_12 n_137 n_29 VDD VSS NOR2X1
Xg4005__9682 state[0] FE_OFN4_n_2 n_28 VDD VSS NAND2X1
Xg4006__2683 n_6 n_16 n_26 VDD VSS NAND2X1
Xg4007 n_22 n_21 VDD VSS CLKINVX2
Xg4008__1309 state[2] n_142 n_20 VDD VSS NOR2X1
Xg4009__6877 state[2] state[3] n_19 VDD VSS NAND2X1
Xg4010__2900 n_141 n_138 n_24 VDD VSS NAND2X1
Xg4011__2391 n_13 n_16 n_23 VDD VSS NAND2X1
Xg4012__7675 state[0] FE_OFN5_state_1 n_22 VDD VSS NAND2X1
Xg4014 n_139 n_18 VDD VSS CLKINVX2
Xg4017 n_141 n_17 VDD VSS INVX2
Xg4026 state[0] n_8 VDD VSS INVX1
Xg4036 EN n_14 VDD VSS INVX1
Xg4037 n_142 n_13 VDD VSS CLKINVX2
Xg4038 COMP_IN n_12 VDD VSS CLKINVX2
Xdrc_bufs4040 n_1 VREF_SEL_8_P[23] VDD VSS CLKINVX8
Xdrc_bufs4044 n_0 VREF_SEL_8_N[23] VDD VSS CLKINVX8
.ENDS controller
